* 4x4 HP Memristive Crossbar

.SUBCKT memristor plus minus PARAMS:
+ Ron=100 Roff=16K Rinit=11K D=10N uv=10F p=1

Gx 0 x value={I(Emem)*uv*Ron/D**2*f(V(x),p)}
Cx x 0 1 IC={(Roff-Rinit)/(Roff-Ron)}
Raux x 0 1000000

Emem plus aux value={-I(Emem)*V(x)*(Roff-Ron)}
Roff aux minus {Roff}

Eflux flux 0 value={SDT(V(plus,minus))}
Echarge charge 0 value={SDT(I(Emem))}

.func f(x,p)={1-(2*x-1)**(2*p)}
.ENDS memristor

* Input voltage sources
V1 row1 0 SIN(0 1.2 1)
V2 row2 0 SIN(0 1.0 1)
V3 row3 0 SIN(0 0.8 1)
V4 row4 0 SIN(0 0.6 1)

* Crossbar
Xm11 row1 col1 memristor PARAMS: Rinit=16000
Xm12 row1 col2 memristor PARAMS: Rinit=8000
Xm13 row1 col3 memristor PARAMS: Rinit=5333
Xm14 row1 col4 memristor PARAMS: Rinit=4000
Xm21 row2 col1 memristor PARAMS: Rinit=8000
Xm22 row2 col2 memristor PARAMS: Rinit=5333
Xm23 row2 col3 memristor PARAMS: Rinit=4000
Xm24 row2 col4 memristor PARAMS: Rinit=16000
Xm31 row3 col1 memristor PARAMS: Rinit=5333
Xm32 row3 col2 memristor PARAMS: Rinit=4000
Xm33 row3 col3 memristor PARAMS: Rinit=16000
Xm34 row3 col4 memristor PARAMS: Rinit=8000
Xm41 row4 col1 memristor PARAMS: Rinit=4000
Xm42 row4 col2 memristor PARAMS: Rinit=16000
Xm43 row4 col3 memristor PARAMS: Rinit=8000
Xm44 row4 col4 memristor PARAMS: Rinit=5333

* Output measurement
Vout1 col1 0 0V
Vout2 col2 0 0V
Vout3 col3 0 0V
Vout4 col4 0 0V

.TRAN 1ms 1s
.PRINT TRAN I(Vout1) I(Vout2) I(Vout3) I(Vout4)
.END
